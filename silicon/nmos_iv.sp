* NMOS Id-Vd characterisation (W/L = 2u/1u): drain swept, gate set per curve
VG g 0 DC 0.9
VD d 0 DC 0
M1 d g 0 0 nmos w=2u l=1u
.dc VD 0 1.8 0.05
.end
